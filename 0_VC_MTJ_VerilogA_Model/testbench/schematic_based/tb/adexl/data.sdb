ADE simulation setup
Run mode: Monte Carlo Sampling
Tests:
  schematic_based:tb:1: schematic_based/tb/schematic, simulator spectre
Corners (nominal off):
  model folders: /projects/home/soc/diyt/MTJ_Model/0_VC_MTJ_VerilogA_Model/model_file
  typical (off): vc_mtj_core.lib[mtj_t]
  MC: vc_mtj_core.lib[mtj_mc]
Monte Carlo Sampling options: mcmethod=mismatch, mcnumpoints=20
