// VC-MTJ compact-model Monte Carlo Spectre testbench

simulator lang=spectre
global 0

// =============================================================================
// 1. Monte Carlo model corner
// =============================================================================

// Monte Carlo mismatch corner
include "../../model_file/vc_mtj_core.lib" section=mtj_mc

// =============================================================================
// 2. VC-MTJ instance
// =============================================================================

// Terminal order: p, n, state
// Initial state: Init=0 for P, Init=1 for AP
I0 (VMTJ net1 State) vc_mtj_3t Init=1

// =============================================================================
// 3. Write-pulse source
// =============================================================================

Vwrite (VMTJ 0) vsource type=pulse dc=0 \
    val0=0 \
    val1=2.4 \
    delay=200p \
    rise=100p \
    fall=100p \
    width=1.5n \
    period=2.5n

Vgnd (net1 0) vsource dc=0

// =============================================================================
// 4. Simulator options
// =============================================================================

simulatorOptions options \
    psfversion="1.4.0" \
    reltol=1e-3 \
    vabstol=1e-6 \
    iabstol=1e-12 \
    temp=27 \
    tnom=27 \
    gmin=1e-12

// =============================================================================
// 5. Monte Carlo mismatch analysis
// =============================================================================

mc1 montecarlo \
    numruns=1 \
    seed=24680 \
    variations=mismatch \
    donominal=no {

    tran tran stop=10n errpreset=conservative
}

// =============================================================================
// 6. Saved outputs
// =============================================================================

// saveahdlvars=all allows internal Verilog-A variables such as R_now, Psw_last, and u_last to be inspected

saveOptions options save=allpub saveahdlvars=all
